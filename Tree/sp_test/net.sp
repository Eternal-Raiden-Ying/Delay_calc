* one example of RC net
.title net

.options post list
.temp 27
.param Supply=1.0
* RC network from CSV

R1 n126 n6 0.282467
R2 n126 n5 1.27058
R3 n126 n13 11.1904
R4 n13 n14 11.4044
R5 n14 n20 17.4414
R6 n20 n21 12.9247
R7 n21 n8 6.12992
R8 n8 n16 10.4147
R9 n16 n18 7.59728
R10 n18 n17 16.2041
R11 n17 n10 7.13455
R12 n10 n9 13.7687
R13 n9 n3 15.7464
R14 n3 n4 17.4897
R15 n4 n11 18.8276
R16 n11 n12 21.7455
R17 n12 n0 11.6598
R18 n0 n99 0.0001
R19 n99 n119 12.0332
R20 n119 n115 21.0581
R21 n115 n116 18.0498
R22 n116 n117 18.0498
R23 n117 n106 18.0498
R24 n106 n107 25.0441
R25 n107 n113 17.3619
R26 n113 n120 11.5397
R27 n120 n122 12.7533
R28 n122 n105 10.5406
R29 n105 n104 5.38785
R30 n104 n109 12.9061
R31 n109 n108 21.8601
R32 n108 n123 17.6648
R33 n123 n124 17.6648
R34 n124 n103 17.6648
R35 n103 n118 12.4889
R36 n118 n111 16.7726
R37 n111 n110 21.9485
R38 n110 n121 17.6648
R39 n121 n112 17.6648
R40 n112 n114 14.8736
R41 n114 n102 15.274
R42 n102 n101 18.0622
R43 n101 n125 13.0545
R44 n125 n100 11.9409
R45 n100 n24 0.0001
R46 n24 n34 7.07261
R47 n34 n33 16.1586
R48 n33 n79 14.3889
R49 n79 n78 5.7548
R50 n78 n63 14.1651
R51 n63 n23 10.2931
R52 n23 n67 13.0517
R53 n67 n93 8.36621
R54 n93 n88 6.08015
R55 n88 n31 5.90446
R56 n31 n32 4.23064
R57 n32 n40 10.2962
R58 n40 n39 5.89568
R59 n39 n96 12.231
R60 n96 n52 19.2271
R61 n52 n51 13.1822
R62 n51 n83 12.2524
R63 n83 n86 12.5922
R64 n86 n90 12.5922
R65 n90 n50 15.1132
R66 n50 n42 12.5728
R67 n42 n43 12.5728
R68 n43 n49 12.5728
R69 n49 n45 12.5728
R70 n45 n46 16.024
R71 n46 n62 9.72322
R72 n62 n53 11.3872
R73 n53 n81 14.5312
R74 n81 n47 13.1547
R75 n47 n48 7.81048
R76 n48 n82 14.3563
R77 n82 n64 15.3626
R78 n64 n65 17.4564
R79 n65 n25 8.72819
R80 n25 n61 11.4776
R81 n61 n91 13.3768
R82 n91 n89 5.17232
R83 n89 n35 11.3067
R84 n35 n22 6.24997
R85 n22 n41 12.0727
R86 n41 n59 12.1308
R87 n59 n60 14.7092
R88 n60 n72 14.9399
R89 n72 n87 6.21262
R90 n87 n80 11.5146
R91 n80 n36 14.9095
R92 n36 n37 20.0208
R93 n37 n44 16.0105
R94 n44 n30 17.6466
R95 n30 n38 18.3078
R96 n38 n74 10.3927
R97 n74 n97 9.53192
R98 n97 n56 9.95547
R99 n56 n57 18.1079
R100 n57 n128 11.1159
R101 n128 n55 1.53247
R102 n128 n98 1.34857
R103 n57 n68 17.4175
R104 n68 n94 9.32809
R105 n94 n77 11.431
R106 n77 n76 6.83215
R107 n76 n95 7.24417
R108 n95 n71 16.6684
R109 n71 n70 12.9422
R110 n70 n69 10.6973
R111 n69 n85 12.2089
R112 n85 n29 17.0752
R113 n29 n28 19.2201
R114 n28 n92 11.0991
R115 n92 n66 12.5174
R116 n66 n73 11.62
R117 n73 n75 10.6004
R118 n75 n54 6.39819
R119 n54 n84 14.3027
R120 n84 n129 8.04227
R121 n129 n58 4.66251
R122 n17 n19 10.9771
R123 n19 n127 8.02557
R124 n127 n15 1.77117
R125 n127 n7 1.09697
C0 n0 0 0.076421f
C3 n3 0 0.56004f
C4 n4 0 0.54623f
C8 n8 0 0.32287f
C9 n9 0 0.75838f
C10 n10 0 0.30139f
C11 n11 0 0.6648f
C12 n12 0 0.60459f
C13 n13 0 0.27548f
C14 n14 0 0.77476f
C16 n16 0 0.2829f
C17 n17 0 0.77614f
C18 n18 0 0.46046f
C19 n19 0 0.33568f
C20 n20 0 0.84563f
C21 n21 0 0.31641f
C22 n22 0 0.42313f
C23 n23 0 0.60908f
C24 n24 0 0.1197f
C25 n25 0 0.22611f
C28 n28 0 0.5439f
C29 n29 0 0.5504f
C30 n30 0 0.57843f
C31 n31 0 0.77278f
C32 n32 0 0.71966f
C33 n33 0 0.45444f
C34 n34 0 0.57392f
C35 n35 0 0.42265f
C36 n36 0 0.57511f
C37 n37 0 0.5793f
C38 n38 0 0.46581f
C39 n39 0 0.25906f
C40 n40 0 0.35053f
C41 n41 0 0.60462f
C42 n42 0 0.71396f
C43 n43 0 0.50756f
C44 n44 0 0.55324f
C45 n45 0 0.7668f
C46 n46 0 0.49067f
C47 n47 0 0.3059f
C48 n48 0 0.39818f
C49 n49 0 0.30535f
C50 n50 0 0.29296f
C51 n51 0 0.67989f
C52 n52 0 0.60786f
C53 n53 0 0.56794f
C54 n54 0 0.66247f
C56 n56 0 0.42147f
C57 n57 0 1.0737f
C59 n59 0 0.39234f
C60 n60 0 0.55542f
C61 n61 0 0.50627f
C62 n62 0 0.51793f
C63 n63 0 0.52635f
C64 n64 0 0.58279f
C65 n65 0 0.37295f
C66 n66 0 0.41589f
C67 n67 0 0.68242f
C68 n68 0 0.40137f
C69 n69 0 0.32678f
C70 n70 0 0.4872f
C71 n71 0 0.55598f
C72 n72 0 0.4456f
C73 n73 0 0.28368f
C74 n74 0 0.44005f
C75 n75 0 0.41009f
C76 n76 0 0.35315f
C77 n77 0 0.29961f
C78 n78 0 0.39958f
C79 n79 0 0.47208f
C80 n80 0 0.35794f
C81 n81 0 0.45545f
C82 n82 0 0.55513f
C83 n83 0 0.46233f
C84 n84 0 0.29296f
C85 n85 0 0.72963f
C86 n86 0 0.50953f
C87 n87 0 0.39881f
C88 n88 0 1.3398f
C89 n89 0 0.28242f
C90 n90 0 0.59888f
C91 n91 0 0.4184f
C92 n92 0 0.6258f
C93 n93 0 0.85601f
C94 n94 0 0.36895f
C95 n95 0 0.44817f
C96 n96 0 0.53303f
C97 n97 0 0.64168f
C99 n99 0 0.077025f
C100 n100 0 0.33279f
C101 n101 0 0.58387f
C102 n102 0 0.45427f
C103 n103 0 0.55131f
C104 n104 0 0.3319f
C105 n105 0 0.30983f
C106 n106 0 0.69912f
C107 n107 0 0.64306f
C108 n108 0 0.60149f
C109 n109 0 0.5454f
C110 n110 0 0.56144f
C111 n111 0 0.68648f
C112 n112 0 0.51279f
C113 n113 0 0.50184f
C114 n114 0 0.54094f
C115 n115 0 0.66992f
C116 n116 0 0.56391f
C117 n117 0 0.45584f
C118 n118 0 0.3889f
C119 n119 0 0.58683f
C120 n120 0 0.45507f
C121 n121 0 0.58907f
C122 n122 0 0.66911f
C123 n123 0 0.50554f
C124 n124 0 0.54944f
C125 n125 0 0.3848f
C126 n126 0 0.25155f
C127 n127 0 0.13993f
Cpin127 n127 0 0.002101p
C128 n128 0 0.12429f
Cpin128 n128 0 0.002101p
C129 n129 0 0.13568f
Cpin129 n129 0 0.002101p

* 驱动电压：PULSE，0 -> Supply，占空比约 50%
* 格式: PULSE(V1 V2 TD TR TF PW PER)
* 这里：0V -> Supply，延时 10ns，上/下降沿 150ps，高电平宽度 10ns，周期 20ns
Vdriv n126 0 PULSE(0 'Supply' 10n 5p 5p 10n 20n)

.option post list
.tran 2p 200n uic

.probe tran v(*)

* * 测量 input_pin 电压最大最小值
* .meas tran Vmax_in1 MAX v(n274) from=0n to=100n
* .meas tran Vmin_in1 MIN v(n274) from=0n to=100n
* .meas tran Vmax_in2 MAX v(n275) from=0n to=100n
* .meas tran Vmin_in2 MIN v(n275) from=0n to=100n

* * 测量驱动 50% -> input_pin 50% 的传播延迟
* * 第一次上升沿：drv 从 0.5*Supply 触发，n274 从 0.5*Supply 作为目标
* .meas tran td_2731070_B_lh
* +TRIG v(n273) VAL='0.5*Supply' RISE=2
* +TARG v(n274) VAL='0.5*Supply' RISE=2

* .meas tran td_2730719_I_lh
* +TRIG v(n273) VAL='0.5*Supply' rise=2
* +TARG v(n275) VAL='0.5*Supply' rise=2

* .meas tran td_2731070_B_hl
* +TRIG v(n273) VAL='0.5*Supply' fall=2
* +TARG v(n274) VAL='0.5*Supply' fall=2

* .meas tran td_2730719_I_hl
* +TRIG v(n273) VAL='0.5*Supply' fall=2
* +TARG v(n275) VAL='0.5*Supply' fall=2
.end
