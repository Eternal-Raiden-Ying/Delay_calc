* one example of RC net
.title net

.options post list
.temp 27
.param Supply=1.0
* RC network from CSV

R1 n273 n252 13.3179
R2 n252 n267 13.0233
R3 n267 n264 13.2096
R4 n264 n266 19.7238
R5 n266 n269 20.4781
R6 n269 n271 9.96436
R7 n271 n263 17.4505
R8 n263 n262 17.4505
R9 n262 n251 29.7342
R10 n251 n239 24.2357
R11 n239 n248 12.3968
R12 n248 n246 12.1818
R13 n246 n247 21.1856
R14 n247 n237 22.7481
R15 n237 n253 12.3968
R16 n253 n270 10.8343
R17 n270 n268 23.7728
R18 n268 n265 23.7088
R19 n265 n255 9.75423
R20 n255 n254 24.8085
R21 n254 n261 27.6314
R22 n261 n258 12.0322
R23 n258 n259 16.3208
R24 n259 n240 15.8871
R25 n240 n250 9.08493
R26 n250 n249 24.7261
R27 n249 n272 24.7261
R28 n272 n257 19.8305
R29 n257 n256 17.6682
R30 n256 n243 17.6682
R31 n243 n242 17.6317
R32 n242 n244 17.5324
R33 n244 n245 20.4544
R34 n245 n238 11.6882
R35 n238 n205 0.0001
R36 n205 n233 11.7421
R37 n233 n235 25.3599
R38 n235 n206 13.6149
R39 n206 n236 8.80654
R40 n236 n226 17.6131
R41 n226 n225 17.6131
R42 n225 n227 17.6131
R43 n227 n228 17.6131
R44 n228 n229 17.6131
R45 n229 n230 17.6131
R46 n230 n224 17.6131
R47 n224 n223 8.96827
R48 n223 n218 13.2482
R49 n218 n203 13.0865
R50 n203 n217 8.80654
R51 n217 n216 17.6131
R52 n216 n215 12.8696
R53 n215 n212 9.48542
R54 n212 n211 18.8043
R55 n211 n208 8.44606
R56 n208 n219 14.5596
R57 n219 n220 19.1103
R58 n220 n231 14.6907
R59 n231 n214 14.3712
R60 n214 n213 15.4286
R61 n213 n210 29.0778
R62 n210 n204 21.0744
R63 n204 n222 9.85549
R64 n222 n232 17.0677
R65 n232 n202 18.3693
R66 n202 n125 0.0001
R67 n125 n166 22.6324
R68 n166 n164 9.19101
R69 n164 n154 12.3963
R70 n154 n153 8.86686
R71 n153 n179 8.86642
R72 n179 n152 21.8143
R73 n152 n175 25.0818
R74 n175 n137 23.839
R75 n137 n119 16.4669
R76 n119 n132 12.4278
R77 n132 n184 17.4883
R78 n184 n148 15.63
R79 n148 n120 15.8455
R80 n120 n147 12.4278
R81 n147 n122 12.4278
R82 n122 n173 12.4278
R83 n173 n130 12.4278
R84 n130 n161 12.4278
R85 n161 n168 15.686
R86 n168 n163 16.7821
R87 n163 n178 14.3272
R88 n178 n149 15.0187
R89 n149 n151 19.1059
R90 n151 n144 13.8548
R91 n144 n145 14.8747
R92 n145 n121 14.76
R93 n121 n162 8.84961
R94 n162 n165 17.6994
R95 n165 n160 14.8525
R96 n160 n159 14.5146
R97 n159 n172 16.9057
R98 n172 n174 17.7048
R99 n174 n176 17.6994
R100 n176 n181 17.7508
R101 n181 n123 8.87628
R102 n123 n180 8.87294
R103 n180 n124 8.88587
R104 n124 n182 8.26406
R105 n182 n192 14.5146
R106 n192 n191 17.3202
R107 n191 n190 16.5717
R108 n190 n155 16.9062
R109 n155 n195 9.29076
R110 n195 n197 9.69623
R111 n197 n199 16.8459
R112 n199 n136 15.5199
R113 n136 n135 8.34266
R114 n135 n171 11.8542
R115 n171 n170 17.5662
R116 n170 n183 13.2929
R117 n183 n143 13.2748
R118 n143 n142 14.0412
R119 n142 n158 16.4355
R120 n158 n193 11.1816
R121 n193 n140 22.0048
R122 n140 n127 22.536
R123 n127 n194 14.2874
R124 n194 n131 14.2874
R125 n131 n198 14.2874
R126 n198 n129 17.4622
R127 n129 n196 15.4975
R128 n196 n128 16.2388
R129 n128 n134 17.8857
R130 n134 n118 17.8857
R131 n118 n133 14.583
R132 n133 n146 12.6332
R133 n146 n167 8.29536
R134 n167 n150 8.93268
R135 n150 n186 10.7843
R136 n186 n185 19.3649
R137 n185 n157 17.6446
R138 n157 n156 17.6446
R139 n156 n177 17.6446
R140 n177 n139 17.6446
R141 n139 n138 17.6446
R142 n138 n141 20.2433
R143 n141 n169 24.6929
R144 n169 n200 20.4598
R145 n200 n201 17.6446
R146 n201 n189 17.6446
R147 n189 n188 17.6446
R148 n188 n187 20.5853
R149 n187 n126 11.763
R150 n126 n57 0.0001
R151 n57 n85 11.9491
R152 n85 n83 17.4673
R153 n83 n82 22.3455
R154 n82 n54 15.8949
R155 n54 n86 8.96181
R156 n86 n91 17.9236
R157 n91 n90 9.12781
R158 n90 n77 16.1045
R159 n77 n116 18.8334
R160 n116 n110 14.5824
R161 n110 n60 17.11
R162 n60 n113 12.5425
R163 n113 n58 12.5425
R164 n58 n112 12.5425
R165 n112 n61 12.5425
R166 n61 n114 12.5425
R167 n114 n62 12.5425
R168 n62 n117 12.5425
R169 n117 n63 12.5425
R170 n63 n104 12.5425
R171 n104 n56 12.5425
R172 n56 n103 12.5425
R173 n103 n71 25.0851
R174 n71 n53 12.5425
R175 n53 n70 12.5425
R176 n70 n73 23.6351
R177 n73 n78 17.9236
R178 n78 n106 17.9236
R179 n106 n66 19.9579
R180 n66 n105 9.69344
R181 n105 n109 16.6736
R182 n109 n92 12.5441
R183 n92 n81 10.6854
R184 n81 n107 20.7672
R185 n107 n115 12.5364
R186 n115 n100 10.5998
R187 n100 n108 22.8117
R188 n108 n74 12.5466
R189 n74 n75 14.5592
R190 n75 n102 14.9851
R191 n102 n67 12.8494
R192 n67 n84 15.1043
R193 n84 n95 7.40421
R194 n95 n98 9.83631
R195 n98 n101 18.5681
R196 n101 n72 11.7019
R197 n72 n111 9.18722
R198 n111 n88 16.6025
R199 n88 n87 26.5799
R200 n87 n79 14.1202
R201 n79 n80 11.1006
R202 n80 n89 12.3598
R203 n89 n76 10.6807
R204 n76 n65 29.8079
R205 n65 n51 28.688
R206 n51 n64 11.605
R207 n64 n96 13.4782
R208 n96 n97 18.8191
R209 n97 n59 19.0287
R210 n59 n69 11.5676
R211 n69 n68 23.1351
R212 n68 n94 21.9791
R213 n94 n55 12.8006
R214 n55 n93 11.818
R215 n93 n99 11.1668
R216 n99 n52 6.28556
R217 n52 n33 0.0001
R218 n33 n35 14.1609
R219 n35 n44 13.7586
R220 n44 n46 15.9911
R221 n46 n40 14.1617
R222 n40 n50 8.07085
R223 n50 n49 7.537
R224 n49 n48 8.92462
R225 n48 n47 5.07212
R226 n47 n42 6.06498
R227 n42 n36 13.2884
R228 n36 n41 18.7364
R229 n41 n43 20.9529
R230 n43 n39 16.5322
R231 n39 n37 16.9626
R232 n37 n38 11.8783
R233 n38 n45 14.2141
R234 n45 n34 10.9288
R235 n34 n1 0.0001
R236 n1 n13 7.69239
R237 n13 n11 13.8314
R238 n11 n15 6.37225
R239 n15 n26 16.2309
R240 n26 n14 13.2378
R241 n14 n22 14.349
R242 n22 n7 15.1555
R243 n7 n23 11.4003
R244 n23 n8 17.2187
R245 n8 n0 13.8432
R246 n0 n5 8.67371
R247 n5 n4 17.3474
R248 n4 n6 17.3474
R249 n6 n21 16.9854
R250 n21 n20 10.4209
R251 n20 n19 17.3044
R252 n19 n2 7.64484
R253 n2 n32 8.65018
R254 n32 n31 14.6923
R255 n31 n30 14.1291
R256 n30 n29 14.1914
R257 n29 n28 15.6229
R258 n28 n27 17.2279
R259 n27 n25 17.231
R260 n25 n16 17.481
R261 n16 n10 8.9202
R262 n10 n12 11.524
R263 n12 n24 12.4004
R264 n24 n9 9.86876
R265 n9 n18 16.0905
R266 n18 n274 6.71076
* R267 n274 n17 4.97724
R268 n223 n234 9.10943
R269 n234 n275 7.90017
* R270 n275 n221 0.0001
* R271 n275 n209 0.283327
* R272 n273 n260 1.06616
C0 n0 0 0.23904f
C1 n1 0 0.073467f
C2 n2 0 0.26105f
C4 n4 0 0.51797f
C5 n5 0 0.30157f
C6 n6 0 0.50933f
C7 n7 0 0.31373f
C8 n8 0 0.57595f
C9 n9 0 0.34762f
C10 n10 0 0.34738f
C11 n11 0 0.30514f
C12 n12 0 0.26507f
C13 n13 0 0.28687f
C14 n14 0 0.45365f
C15 n15 0 0.30882f
C16 n16 0 0.35672f
C18 n18 0 0.43765f
C19 n19 0 0.48866f
C20 n20 0 0.39176f
C21 n21 0 0.46229f
C22 n22 0 0.50996f
C23 n23 0 0.45539f
C24 n24 0 0.27932f
C25 n25 0 0.6705f
C26 n26 0 0.19115f
C27 n27 0 0.27097f
C28 n28 0 0.52788f
C29 n29 0 0.44411f
C30 n30 0 0.42286f
C31 n31 0 0.6783f
C32 n32 0 0.23387f
C33 n33 0 0.3258f
C34 n34 0 0.038669f
C35 n35 0 0.37103f
C36 n36 0 0.39583f
C37 n37 0 0.28854f
C38 n38 0 0.30232f
C39 n39 0 0.4025f
C40 n40 0 0.2411f
C41 n41 0 0.57576f
C42 n42 0 0.63072f
C43 n43 0 0.36194f
C44 n44 0 0.30338f
C45 n45 0 0.54886f
C46 n46 0 0.45272f
C47 n47 0 0.41428f
C48 n48 0 0.55652f
C49 n49 0 0.85899f
C50 n50 0 0.63685f
C51 n51 0 0.33731f
C52 n52 0 0.085814f
C53 n53 0 0.16811f
C54 n54 0 0.37297f
C55 n55 0 0.37142f
C56 n56 0 0.1653f
C57 n57 0 0.050139f
C58 n58 0 0.15962f
C59 n59 0 0.16787f
C60 n60 0 0.21203f
C61 n61 0 0.16892f
C62 n62 0 0.16279f
C63 n63 0 0.16784f
C64 n64 0 0.34282f
C65 n65 0 0.46584f
C66 n66 0 0.31183f
C67 n67 0 0.3215f
C68 n68 0 0.39647f
C69 n69 0 0.54313f
C70 n70 0 0.29813f
C71 n71 0 0.41862f
C72 n72 0 0.36576f
C73 n73 0 0.60101f
C74 n74 0 0.33948f
C75 n75 0 0.42406f
C76 n76 0 0.34621f
C77 n77 0 0.44064f
C78 n78 0 0.46231f
C79 n79 0 0.29093f
C80 n80 0 0.33271f
C81 n81 0 0.34762f
C82 n82 0 0.49136f
C83 n83 0 0.48339f
C84 n84 0 0.43467f
C85 n85 0 0.50454f
C86 n86 0 0.4473f
C87 n87 0 0.57718f
C88 n88 0 0.53831f
C89 n89 0 0.31852f
C90 n90 0 0.39153f
C91 n91 0 0.32792f
C92 n92 0 0.3326f
C93 n93 0 0.23527f
C94 n94 0 0.51252f
C95 n95 0 0.34548f
C96 n96 0 0.21594f
C97 n97 0 0.57931f
C98 n98 0 0.38779f
C99 n99 0 0.295f
C100 n100 0 0.41446f
C101 n101 0 0.56948f
C102 n102 0 0.33017f
C103 n103 0 0.33975f
C104 n104 0 0.29344f
C105 n105 0 0.40426f
C106 n106 0 0.48031f
C107 n107 0 0.42971f
C108 n108 0 0.51926f
C109 n109 0 0.34537f
C110 n110 0 0.47702f
C111 n111 0 0.23986f
C112 n112 0 0.29616f
C113 n113 0 0.33696f
C114 n114 0 0.27785f
C115 n115 0 0.17904f
C116 n116 0 0.42879f
C117 n117 0 0.29994f
C118 n118 0 0.17792f
C119 n119 0 0.15195f
C120 n120 0 0.22665f
C121 n121 0 0.26077f
C122 n122 0 0.20646f
C123 n123 0 0.23163f
C124 n124 0 0.23833f
C125 n125 0 0.25081f
C126 n126 0 0.078246f
C127 n127 0 0.27206f
C128 n128 0 0.21924f
C129 n129 0 0.28154f
C130 n130 0 0.21073f
C131 n131 0 0.23805f
C132 n132 0 0.3542f
C133 n133 0 0.35306f
C134 n134 0 0.41234f
C135 n135 0 0.31111f
C136 n136 0 0.45047f
C137 n137 0 0.46983f
C138 n138 0 0.58829f
C139 n139 0 0.47876f
C140 n140 0 0.52415f
C141 n141 0 0.44812f
C142 n142 0 0.44001f
C143 n143 0 0.64588f
C144 n144 0 0.32011f
C145 n145 0 0.46159f
C146 n146 0 0.23548f
C147 n147 0 0.28061f
C148 n148 0 0.39396f
C149 n149 0 0.49211f
C150 n150 0 0.21741f
C151 n151 0 0.5692f
C152 n152 0 0.52163f
C153 n153 0 0.33257f
C154 n154 0 0.32274f
C155 n155 0 0.31112f
C156 n156 0 0.55803f
C157 n157 0 0.4765f
C158 n158 0 0.38096f
C159 n159 0 0.66823f
C160 n160 0 0.46444f
C161 n161 0 0.2831f
C162 n162 0 0.47038f
C163 n163 0 0.41159f
C164 n164 0 0.25099f
C165 n165 0 0.26999f
C166 n166 0 0.50252f
C167 n167 0 0.27339f
C168 n168 0 0.34402f
C169 n169 0 0.51454f
C170 n170 0 0.48476f
C171 n171 0 0.37081f
C172 n172 0 0.26189f
C173 n173 0 0.29231f
C174 n174 0 0.6862f
C175 n175 0 0.52474f
C176 n176 0 0.45709f
C177 n177 0 0.39426f
C178 n178 0 0.2855f
C179 n179 0 0.30194f
C180 n180 0 0.25717f
C181 n181 0 0.30011f
C182 n182 0 0.43121f
C183 n183 0 0.3902f
C184 n184 0 0.40675f
C185 n185 0 0.47425f
C186 n186 0 0.39482f
C187 n187 0 0.49044f
C188 n188 0 0.59259f
C189 n189 0 0.43334f
C190 n190 0 0.6443f
C191 n191 0 0.30577f
C192 n192 0 0.46972f
C193 n193 0 0.28576f
C194 n194 0 0.28613f
C195 n195 0 0.27223f
C196 n196 0 0.301f
C197 n197 0 0.33607f
C198 n198 0 0.30365f
C199 n199 0 0.48505f
C200 n200 0 0.44073f
C201 n201 0 0.40153f
C202 n202 0 0.23968f
C203 n203 0 0.20054f
C204 n204 0 0.25339f
C205 n205 0 0.080655f
C206 n206 0 0.25067f
C208 n208 0 0.30773f
C210 n210 0 0.63062f
C211 n211 0 0.38956f
C212 n212 0 0.315f
C213 n213 0 0.44087f
C214 n214 0 0.42207f
C215 n215 0 0.32402f
C216 n216 0 0.43147f
C217 n217 0 0.28289f
C218 n218 0 0.39038f
C219 n219 0 0.53906f
C220 n220 0 0.39986f
C222 n222 0 0.33417f
C223 n223 0 0.34048f
C224 n224 0 0.45625f
C225 n225 0 0.56684f
C226 n226 0 0.45954f
C227 n227 0 0.48702f
C228 n228 0 0.4457f
C229 n229 0 0.44499f
C230 n230 0 0.27967f
C231 n231 0 0.23818f
C232 n232 0 0.50152f
C233 n233 0 0.59371f
C234 n234 0 0.34174f
C235 n235 0 0.45811f
C236 n236 0 0.26972f
C237 n237 0 0.16616f
C238 n238 0 0.082143f
C239 n239 0 0.1429f
C240 n240 0 0.28563f
C242 n242 0 0.56512f
C243 n243 0 0.34513f
C244 n244 0 0.41525f
C245 n245 0 0.48218f
C246 n246 0 0.21023f
C247 n247 0 0.63268f
C248 n248 0 0.35355f
C249 n249 0 0.59578f
C250 n250 0 0.35324f
C251 n251 0 0.7171f
C252 n252 0 0.43144f
C253 n253 0 0.34834f
C254 n254 0 0.48487f
C255 n255 0 0.44063f
C256 n256 0 0.4895f
C257 n257 0 0.64031f
C258 n258 0 0.3566f
C259 n259 0 0.36206f
C261 n261 0 0.40978f
C262 n262 0 0.34018f
C263 n263 0 0.53068f
C264 n264 0 0.40497f
C265 n265 0 0.19478f
C266 n266 0 0.51082f
C267 n267 0 0.43189f
C268 n268 0 0.72559f
C269 n269 0 0.3996f
C270 n270 0 0.16344f
C271 n271 0 0.23069f
C272 n272 0 0.31541f
C273 n273 0 0.20963f
C274 n274 0 0.092998f
Cpin274 n274 0 0.002033p
C275 n275 0 0.011709f
Cpin275 n275 0 0.000609p

* 驱动电压：PULSE，0 -> Supply，占空比约 50%
* 格式: PULSE(V1 V2 TD TR TF PW PER)
* 这里：0V -> Supply，延时 10ns，上/下降沿 150ps，高电平宽度 10ns，周期 20ns
Vdriv n273 0 PULSE(0 'Supply' 10n 50p 50p 10n 20n)

.option post list
.tran 2p 200n uic

.probe tran v(n275) v(n274)

* 测量 input_pin 电压最大最小值
.meas tran Vmax_in1 MAX v(n274) from=0n to=100n
.meas tran Vmin_in1 MIN v(n274) from=0n to=100n
.meas tran Vmax_in2 MAX v(n275) from=0n to=100n
.meas tran Vmin_in2 MIN v(n275) from=0n to=100n

* 测量驱动 50% -> input_pin 50% 的传播延迟
* 第一次上升沿：drv 从 0.5*Supply 触发，n274 从 0.5*Supply 作为目标
.meas tran td_2731070_B_lh
+TRIG v(n273) VAL='0.5*Supply' RISE=2
+TARG v(n274) VAL='0.5*Supply' RISE=2

.meas tran td_2730719_I_lh
+TRIG v(n273) VAL='0.5*Supply' rise=2
+TARG v(n275) VAL='0.5*Supply' rise=2

.meas tran td_2731070_B_hl
+TRIG v(n273) VAL='0.5*Supply' fall=2
+TARG v(n274) VAL='0.5*Supply' fall=2

.meas tran td_2730719_I_hl
+TRIG v(n273) VAL='0.5*Supply' fall=2
+TARG v(n275) VAL='0.5*Supply' fall=2
.end
